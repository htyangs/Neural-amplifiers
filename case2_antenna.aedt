# Ansys Electronics Desktop project, version 2022.2
materials:
  vacuum: permittivity=1
  Rogers RO3010 (tm): permittivity=10.2 dielectric_loss_tangent=0.0035
  pec: conductivity=1e+30
  teflon_based: permittivity=2.08 dielectric_loss_tangent=0.001
  PMLGroup1_Z_1: permittivity{anisotropic component1=1.7262773 component2=1.7262773 component3=0.28964061} permeability{anisotropic component1=1.7262773 component2=1.7262773 component3=0.28964061} dielectric_loss_tangent{anisotropic component1=1 component2=1 component3=-1} magnetic_loss_tangent{anisotropic component1=1 component2=1 component3=-1}
  PMLGroup1_XZ_1: permittivity{anisotropic component1=1 component2=0.01 component3=1} permeability{anisotropic component1=1 component2=0.01 component3=1} dielectric_loss_tangent{anisotropic component1=0 component2=596.00664 component3=0} magnetic_loss_tangent{anisotropic component1=0 component2=596.00664 component3=0}
  PMLGroup1_YZ_1: permittivity{anisotropic component1=0.01 component2=1 component3=1} permeability{anisotropic component1=0.01 component2=1 component3=1} dielectric_loss_tangent{anisotropic component1=596.00664 component2=0 component3=0} magnetic_loss_tangent{anisotropic component1=596.00664 component2=0 component3=0}
  PMLGroup1_XYZ_1: permittivity{anisotropic component1=1.7262773 component2=1.7262773 component3=1.7262773} permeability{anisotropic component1=1.7262773 component2=1.7262773 component3=1.7262773} dielectric_loss_tangent{anisotropic component1=1 component2=1 component3=1} magnetic_loss_tangent{anisotropic component1=1 component2=1 component3=1}
  PMLGroup2_Z_1: permittivity{anisotropic component1=1.7262773 component2=1.7262773 component3=0.28964061} permeability{anisotropic component1=1.7262773 component2=1.7262773 component3=0.28964061} dielectric_loss_tangent{anisotropic component1=1 component2=1 component3=-1} magnetic_loss_tangent{anisotropic component1=1 component2=1 component3=-1}
  PMLGroup2_XZ_1: permittivity{anisotropic component1=1 component2=0.01 component3=1} permeability{anisotropic component1=1 component2=0.01 component3=1} dielectric_loss_tangent{anisotropic component1=0 component2=596.00664 component3=0} magnetic_loss_tangent{anisotropic component1=0 component2=596.00664 component3=0}
  PMLGroup2_YZ_1: permittivity{anisotropic component1=0.01 component2=1 component3=1} permeability{anisotropic component1=0.01 component2=1 component3=1} dielectric_loss_tangent{anisotropic component1=596.00664 component2=0 component3=0} magnetic_loss_tangent{anisotropic component1=596.00664 component2=0 component3=0}
  PMLGroup2_XYZ_1: permittivity{anisotropic component1=1.7262773 component2=1.7262773 component3=1.7262773} permeability{anisotropic component1=1.7262773 component2=1.7262773 component3=1.7262773} dielectric_loss_tangent{anisotropic component1=1 component2=1 component3=1} magnetic_loss_tangent{anisotropic component1=1 component2=1 component3=1}
  CSF: permittivity=79.1 conductivity=2.14
  Dura: permittivity=40.7 conductivity=0.65

design HFSSDesign1 (HFSS, DrivenTerminal, model units mm)
geometry:
  Rectangle1 = rectangle(corner=(0mm, 0mm, 0mm), z_size=-0.5mm, x_size=3mm)
  Rectangle2 = rectangle(corner=(2.7mm, 0mm, -0.5mm), z_size=(-2-0.15) mm, x_size=0.2mm)
  Rectangle5 = rectangle(corner=(2.9mm, 0mm, -2.65mm), z_size=-0.2mm, x_size=-0.7mm)
  Rectangle6 = rectangle(corner=(2.2mm, 0mm, -2.65mm), z_size=1.8mm, x_size=0.2mm)
  Rectangle7 = rectangle(corner=(2.4mm, 0mm, -0.85mm), z_size=0.2mm, x_size=-0.6mm)
  Rectangle8 = rectangle(corner=(1.8mm, 0mm, -0.85mm), z_size=-1.8mm, x_size=0.2mm)
  Rectangle9 = rectangle(corner=(2mm, 0mm, -2.65mm), z_size=-0.2mm, x_size=-0.6mm)
  Rectangle6_1 = Rectangle6.duplicate_along_line(step=(-0.8mm, 0mm, 0mm), total=2)
  Rectangle7_1 = Rectangle7.duplicate_along_line(step=(-0.8mm, 0mm, 0mm), total=2)
  Rectangle8_1 = Rectangle8.duplicate_along_line(step=(-0.8mm, 0mm, 0mm), total=2)
  Rectangle9_1 = Rectangle9.duplicate_along_line(step=(-0.8mm, 0mm, 0mm), total=2)
  Rectangle6_1_1 = Rectangle6_1.duplicate_along_line(step=(-0.8mm, 0mm, 0mm), total=2)
  Rectangle8_1_1 = Rectangle8_1.duplicate_along_line(step=(-0.8mm, 0mm, 0mm), total=2)
  Rectangle7_1_1 = Rectangle7_1.duplicate_along_line(step=(-0.8mm, 0mm, 0mm), total=2)
  [Rectangle1, Rectangle2, Rectangle5..Rectangle9, Rectangle6_1, Rectangle7_1, Rectangle8_1, Rectangle9_1, Rectangle6_1_1, Rectangle8_1_1, Rectangle7_1_1].rotate(axis=X, angle=90deg)
  Box1 [Rogers RO3010 (tm)] = box(corner=(3mm, 0mm, 0mm), size=(-3mm, 3mm, 0.25mm))
  Box2 [Rogers RO3010 (tm)] = box(corner=(3mm, 0mm, 0mm), size=(-3mm, 3mm, -0.25mm))
  Feed [pec] = cylinder(axis=Z, base_centre=(2.7mm, 0.25mm, 0mm), radius=0.125mm, height=-0.25mm)
  Rectangle10 = rectangle(corner=(0mm, 0mm, -0.25mm), x_size=3mm, y_size=1.2mm)
  Rectangle11 = rectangle(corner=(0mm, 1.3mm, -0.25mm), x_size=3mm, y_size=0.1mm)
  Rectangle11_1, Rectangle11_2, Rectangle11_3 = Rectangle11.duplicate_along_line(step=(0mm, 0.25mm, 0mm), total=4)
  Rectangle12 = rectangle(corner=(0mm, 2.35mm, -0.25mm), x_size=3mm, y_size=0.65mm)
  Coax [pec] = cylinder(axis=Z, base_centre=(2.7mm, 0.25mm, -0.25mm), radius=0.125mm, height=-0.1mm)
  Port [pec] = cylinder(axis=Z, base_centre=(2.7mm, 0.25mm, -0.35mm), radius=0.25mm, height=-0.05mm)
  Circle1 = circle(normal=Z, centre=(2.7mm, 0.25mm, -0.35mm), radius=0.25mm)
  Cylinder1 [teflon_based] = cylinder(axis=Z, base_centre=(2.7mm, 0.25mm, -0.25mm), radius=0.25mm, height=-0.1mm)
  Circle2 = circle(normal=Z, centre=(2.7mm, 0.25mm, -0.25mm), radius=0.24839485mm)
  Rectangle10.subtract(Circle2)
  RadiatingSurface [vacuum] = region(absolute_offset=30.612245mm on all sides)
  coordinate_system FaceCS1 = face of RadiatingSurface: Origin=(36.112245, -34.112245, 30.912245) FaceID=RadiatingSurface.face(+z) AxisPosn=(36.112245, 37.112245, 30.912245) WhichAxis=X ZRotationAngle=0deg XOffset=0mm YOffset=0mm
  PML_RadiatingSurface_1 [PMLGroup2_Z_1, oriented by FaceCS1] = sweep_along_normal(RadiatingSurface.face(+z), length=31.716928mm)
  coordinate_system FaceCS2 = face of RadiatingSurface: Origin=(36.112245, 37.112245, -31.012245) FaceID=RadiatingSurface.face(-z) AxisPosn=(36.112245, -34.112245, -31.012245) WhichAxis=X ZRotationAngle=0deg XOffset=0mm YOffset=0mm
  PML_RadiatingSurface_2 [PMLGroup2_Z_1, oriented by FaceCS2] = sweep_along_normal(RadiatingSurface.face(-z), length=31.716928mm)
  coordinate_system FaceCS3 = face of RadiatingSurface: Origin=(-33.112245, -34.112245, 30.912245) FaceID=RadiatingSurface.face(-y) AxisPosn=(-33.112245, -34.112245, -31.012245) WhichAxis=X ZRotationAngle=0deg XOffset=0mm YOffset=0mm
  PML_RadiatingSurface_3 [PMLGroup2_Z_1, oriented by FaceCS3] = sweep_along_normal(RadiatingSurface.face(-y), length=31.716928mm)
  coordinate_system FaceCS4 = face of RadiatingSurface: Origin=(-33.112245, 37.112245, 30.912245) FaceID=RadiatingSurface.face(-x) AxisPosn=(-33.112245, 37.112245, -31.012245) WhichAxis=X ZRotationAngle=0deg XOffset=0mm YOffset=0mm
  PML_RadiatingSurface_4 [PMLGroup2_Z_1, oriented by FaceCS4] = sweep_along_normal(RadiatingSurface.face(-x), length=31.716928mm)
  coordinate_system FaceCS5 = face of RadiatingSurface: Origin=(36.112245, 37.112245, 30.912245) FaceID=RadiatingSurface.face(+y) AxisPosn=(36.112245, 37.112245, -31.012245) WhichAxis=X ZRotationAngle=0deg XOffset=0mm YOffset=0mm
  PML_RadiatingSurface_5 [PMLGroup2_Z_1, oriented by FaceCS5] = sweep_along_normal(RadiatingSurface.face(+y), length=31.716928mm)
  coordinate_system FaceCS6 = face of RadiatingSurface: Origin=(36.112245, -34.112245, 30.912245) FaceID=RadiatingSurface.face(+x) AxisPosn=(36.112245, -34.112245, -31.012245) WhichAxis=X ZRotationAngle=0deg XOffset=0mm YOffset=0mm
  PML_RadiatingSurface_6 [PMLGroup2_Z_1, oriented by FaceCS6] = sweep_along_normal(RadiatingSurface.face(+x), length=31.716928mm)
  PML_RadiatingSurface_7 [PMLGroup2_XZ_1, oriented by FaceCS3] = sweep_along_normal(PML_RadiatingSurface_1.face(at (1.5, -34.1122, 46.7707)), length=31.716928mm)
  PML_RadiatingSurface_8 [PMLGroup2_XZ_1, oriented by FaceCS4] = sweep_along_normal(PML_RadiatingSurface_1.face(at (-33.1122, 1.5, 46.7707)), length=31.716928mm)
  PML_RadiatingSurface_9 [PMLGroup2_XZ_1, oriented by FaceCS5] = sweep_along_normal(PML_RadiatingSurface_1.face(at (1.5, 37.1122, 46.7707)), length=31.716928mm)
  PML_RadiatingSurface_10 [PMLGroup2_YZ_1, oriented by FaceCS1] = sweep_along_normal(PML_RadiatingSurface_1.face(at (36.1122, 1.5, 46.7707)), length=31.716928mm)
  coordinate_system FaceCS7 = face of RadiatingSurface: Origin=(36.112245, -34.112245, -31.012245) FaceID=RadiatingSurface.face(-z) AxisPosn=(-33.112245, -34.112245, -31.012245) WhichAxis=X ZRotationAngle=0deg XOffset=0mm YOffset=0mm
  PML_RadiatingSurface_11 [PMLGroup2_YZ_1, oriented by FaceCS7] = sweep_along_normal(PML_RadiatingSurface_2.face(at (1.5, -34.1122, -46.8707)), length=31.716928mm)
  coordinate_system FaceCS8 = face of RadiatingSurface: Origin=(-33.112245, -34.112245, -31.012245) FaceID=RadiatingSurface.face(-z) AxisPosn=(-33.112245, 37.112245, -31.012245) WhichAxis=X ZRotationAngle=0deg XOffset=0mm YOffset=0mm
  PML_RadiatingSurface_12 [PMLGroup2_YZ_1, oriented by FaceCS8] = sweep_along_normal(PML_RadiatingSurface_2.face(at (-33.1122, 1.5, -46.8707)), length=31.716928mm)
  PML_RadiatingSurface_13 [PMLGroup2_XZ_1, oriented by FaceCS2] = sweep_along_normal(PML_RadiatingSurface_2.face(at (1.5, 37.1122, -46.8707)), length=31.716928mm)
  PML_RadiatingSurface_14 [PMLGroup2_YZ_1, oriented by FaceCS2] = sweep_along_normal(PML_RadiatingSurface_2.face(at (36.1122, 1.5, -46.8707)), length=31.716928mm)
  PML_RadiatingSurface_15 [PMLGroup2_YZ_1, oriented by FaceCS3] = sweep_along_normal(PML_RadiatingSurface_3.face(at (-33.1122, -49.9707, -0.05)), length=31.716928mm)
  PML_RadiatingSurface_16 [PMLGroup2_YZ_1, oriented by FaceCS6] = sweep_along_normal(PML_RadiatingSurface_3.face(at (36.1122, -49.9707, -0.05)), length=31.716928mm)
  PML_RadiatingSurface_17 [PMLGroup2_YZ_1, oriented by FaceCS4] = sweep_along_normal(PML_RadiatingSurface_4.face(at (-48.9707, 37.1122, -0.05)), length=31.716928mm)
  PML_RadiatingSurface_18 [PMLGroup2_YZ_1, oriented by FaceCS5] = sweep_along_normal(PML_RadiatingSurface_5.face(at (36.1122, 52.9707, -0.05)), length=31.716928mm)
  PML_RadiatingSurface_19 [PMLGroup2_XYZ_1, oriented by FaceCS3] = sweep_along_normal(PML_RadiatingSurface_7.face(at (-33.1122, -49.9707, 46.7707)), length=31.716928mm)
  PML_RadiatingSurface_20 [PMLGroup2_XYZ_1, oriented by FaceCS1] = sweep_along_normal(PML_RadiatingSurface_7.face(at (36.1122, -49.9707, 46.7707)), length=31.716928mm)
  PML_RadiatingSurface_21 [PMLGroup2_XYZ_1, oriented by FaceCS4] = sweep_along_normal(PML_RadiatingSurface_8.face(at (-48.9707, 37.1122, 46.7707)), length=31.716928mm)
  PML_RadiatingSurface_22 [PMLGroup2_XYZ_1, oriented by FaceCS5] = sweep_along_normal(PML_RadiatingSurface_9.face(at (36.1122, 52.9707, 46.7707)), length=31.716928mm)
  PML_RadiatingSurface_23 [PMLGroup2_XYZ_1, oriented by FaceCS8] = sweep_along_normal(PML_RadiatingSurface_11.face(at (-33.1122, -49.9707, -46.8707)), length=31.716928mm)
  PML_RadiatingSurface_24 [PMLGroup2_XYZ_1, oriented by FaceCS7] = sweep_along_normal(PML_RadiatingSurface_11.face(at (36.1122, -49.9707, -46.8707)), length=31.716928mm)
  coordinate_system FaceCS9 = face of RadiatingSurface: Origin=(-33.112245, 37.112245, -31.012245) FaceID=RadiatingSurface.face(-z) AxisPosn=(36.112245, 37.112245, -31.012245) WhichAxis=X ZRotationAngle=0deg XOffset=0mm YOffset=0mm
  PML_RadiatingSurface_25 [PMLGroup2_XYZ_1, oriented by FaceCS9] = sweep_along_normal(PML_RadiatingSurface_12.face(at (-48.9707, 37.1122, -46.8707)), length=31.716928mm)
  PML_RadiatingSurface_26 [PMLGroup2_XYZ_1, oriented by FaceCS2] = sweep_along_normal(PML_RadiatingSurface_13.face(at (36.1122, 52.9707, -46.8707)), length=31.716928mm)
  Box3 [Dura] = box(corner=((-4+1.5) mm, (-5+1.5) mm, 0.25mm), size=(8mm, 10mm, 0.05mm))
  Box4 [CSF] = box(corner=((-4+1.5) mm, (-5 +1.5) mm, 0.25mm), size=(8mm, 10mm, -0.649mm))
  Box1_1 = Box1.copy()
  Box2_1 = Box2.copy()
  Coax_1 = Coax.copy()
  Cylinder1_1 = Cylinder1.copy()
  Feed_1 = Feed.copy()
  Port_1 = Port.copy()
  Box4.subtract(Box1_1, Box2_1, Coax_1, Cylinder1_1, Feed_1, Port_1)
  group PMLGroup2 = PML_RadiatingSurface_1..PML_RadiatingSurface_26
boundaries and excitations:
  antenna: Perfect E Objects=[Rectangle1, Rectangle2, Rectangle5, Rectangle6, Rectangle6_1, Rectangle6_1_1, Rectangle7, Rectangle7_1, Rectangle7_1_1, Rectangle8, Rectangle8_1, Rectangle8_1_1, Rectangle9, Rectangle9_1]
  ground: Perfect E Objects=[Rectangle10, Rectangle11, Rectangle11_1, Rectangle11_2, Rectangle11_3, Rectangle12]
  coax_outer: Perfect E Faces=Cylinder1.face(1 of 3)
  PML_radiation1: Radiation Faces=RadiatingSurface.face(+z) IsForPML
  PML_radiation2: Radiation Faces=RadiatingSurface.face(-z) IsForPML
  PML_radiation3: Radiation Faces=RadiatingSurface.face(-y) IsForPML
  PML_radiation4: Radiation Faces=RadiatingSurface.face(-x) IsForPML
  PML_radiation5: Radiation Faces=RadiatingSurface.face(+y) IsForPML
  PML_radiation6: Radiation Faces=RadiatingSurface.face(+x) IsForPML
  Coax_T1: Terminal port=1 Faces=Coax.face(2 of 3) TerminalResistance=50ohm
  1: Wave Port Faces=Circle1.face NumModes=1
  reference conductors: Port
setups:
  Setup1: HfssDriven Frequency=2.45GHz MaxDeltaS=0.02 MaximumPasses=6 MinimumPasses=1 MinimumConvergedPasses=1 PercentRefinement=30 BasisOrder=1 PortAccuracy=2 DrivenSolverType="Direct Solver"
    sweep Sweep: 2.3GHz to 2.8GHz, 201 points; Type=Discrete SaveFields
source amplitudes:
  1:1: 1V 0deg
radiation setups:
  3D: Infinite Sphere Theta=0deg..180deg step 2deg Phi=-180deg..180deg step 2deg
  Elevation: Infinite Sphere Theta=-180deg..180deg step 1deg Phi=0deg..90deg step 90deg
  Azimuth: Infinite Sphere Theta=90deg..90deg step 0deg Phi=-180deg..180deg step 1deg
field plots:
  Vector_Jsurf1: Jsurf over Rectangle1.face(#28) Rectangle2.face(#40) Rectangle5.face(#88) Rectangle6.face(#100) Rectangle6_1.face(1 of 1) Rectangle6_1_1.face Rectangle7.face(#112) Rectangle7_1.face(1 of 1) Rectangle7_1_1.face Rectangle8.face(#124) Rectangle8_1.face(1 of 1) Rectangle8_1_1.face Rectangle9.face(#136) Rectangle9_1.face on Setup1 : LastAdaptive at Freq=2.45GHz Phase=0deg
  Vector_E1: E Field in Box3, Box1, Box2, Cylinder1 on Setup1 : LastAdaptive at Freq=2.45GHz Phase=0deg
reports:
  Realized Gain Plot 1: dB(RealizedGainTotal) vs Freq on Setup1 : Sweep, 3D [Phi=90deg Theta=0deg]
  Terminal S Parameter Plot 1: dB(St(Coax_T1,Coax_T1)) vs Freq on Setup1 : Sweep; markers m1 at 2.2413793GHz, m2 at 2.2413793GHz
  Realized Gain Plot 2: dB(RealizedGainTotal) vs Phi, Theta on Setup1 : LastAdaptive, 3D [Freq=2.45GHz]
